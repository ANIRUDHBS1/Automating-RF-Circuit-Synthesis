// Design: EE4902/ResistiveFeedbackLNA
simulator lang=spectre
global 0 vdd!
parameters m1=20 m2=80 Rf=300 Ib=10u Ls=1p Lg=100n circ_temp=27 VDD=0.9 frf=1.58G prf=-40
include "/cad/library/TSMC/tsmc_28/28/28HPC_RF/tn28crsp029w1_1_8_2p2a/tsmcN28/../models/spectre/toplevel.scs" section=TOP_TT

// EE4902/ResistiveFeedbackLNA/schematic
M0 (net3 net7 net6 net6) nmos_rf_nw multi=m1 dw1=-1.4923e-20 lr=30n nr=4 sa5=495.907n sa6=512.134n sa7=450.098n sodxa=80n sodxb=80n wr=600n dinsaflag=0 ngcon=2 sobn=835.00n sobe=410.0n sobs=835.00n sobw=410.0n cbflag=2 rcmflag=1
M1 (net3 Vbias vdd! vdd!) pmos_rf_nw multi=m2 dw1=-1.4923e-20 lr=30n nr=4 sa5=495.907n sa6=512.134n sa7=450.098n sodxa=80n sodxb=80n wr=600n dinsaflag=0 ngcon=2 sobn=835.00n sobe=410.0n sobs=835.00n sobw=410.0n cbflag=2 rcmflag=1
M2 (Vbias Vbias vdd! vdd!) pmos_rf_nw multi=1 dw1=-1.4923e-20 lr=30n nr=4 sa5=495.907n sa6=512.134n sa7=450.098n sodxa=80n sodxb=80n wr=600n dinsaflag=0 ngcon=2 sobn=835n sobe=410n sobs=835n sobw=410n cbflag=2 rcmflag=1
R0 (net2 net3) resistor r=Rf
I0 (Vbias 0) isource dc=Ib type=dc
C0 (net1 net2) capacitor c=1u
C1 (net3 net4) capacitor c=1u
Vs (net1 0) port r=50 dc=0 type=sine freq=frf dbm=prf freq2=frf + 1M dbm2=prf fundname="RF1" fundname2="RF2" mag = 1
E0 (Vout 0 net4 0) vcvs gain=1.0
V0 (vdd! 0) vsource dc=VDD type=dc
PORT2 (Vout 0) port r=50 dc=0 type=dc
L1 (0 net6) inductor l=Ls
L0 (net2 net7) inductor l=Lg
simulatorOptions options temp=circ_temp

Settings options rawfmt=psfascii
hbtest hb autoharms=yes autotstab=yes oversample=[1 1] funds=["RF1" "RF2"] maxharms=[3 3] errpreset=moderate save=all
